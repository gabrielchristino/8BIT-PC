Official TPS63070 original library compatibility trial
.include "/mnt/c/Users/gabri/projetos/isa1/references/vendor/tps63070/original/SLVMBP8/TPS63070_PSPICE_TRANS/TPS63070_TRANS.LIB"
VIN vin 0 5
VEN en 0 PWL(0 0 10u 0 11u 5)
XREG en fb 0 0 l1 l2 pg 0 0 aux vin vin out out 0 TPS63070_TRANS
L1 l1 intermediate 1.5u
RESR intermediate l2 .03
CIN vin 0 20u
COUT out 0 66u
CAUX aux 0 100n
RUP out fb 55.4k
RDOWN fb 0 10k
RPG pg vin 100k
RLOAD out 0 100
.options method=gear reltol=.003 abstol=1n vntol=1u rshunt=1e12 cshunt=1e-15
.tran 20n 1m
.measure tran final_v FIND V(out) AT=.99m
.end
