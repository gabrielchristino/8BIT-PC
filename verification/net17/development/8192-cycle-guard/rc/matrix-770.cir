NET17 conditional keypad excess-capacitance corner 770
VCC vcc 0 4.5
VDRV drv 0 0.44
VSEL0 ctl0 0 PWL(0 1 19.999u 1 20u 0)
SROW0 drive0 drv ctl0 0 ROW
RS0 drive0 n0 828.2
VSEL1 ctl1 0 PWL(0 0 19.999u 0 20u 1)
SROW1 drive1 drv ctl1 0 ROW
RS1 drive1 n1 828.2
VSEL2 ctl2 0 PWL(0 0 19.999u 0 20u 0)
SROW2 drive2 drv ctl2 0 ROW
RS2 drive2 n2 828.2
VSEL3 ctl3 0 PWL(0 0 19.999u 0 20u 0)
SROW3 drive3 drv ctl3 0 ROW
RS3 drive3 n3 828.2
.model ROW SW(Ron=0.01 Roff=1e15 Vt=0.5 Vh=0)
RP0 vcc n0 126000.0
CP0 n0 0 2e-08
IL0 0 n0 -3e-06
RP1 vcc n1 126000.0
CP1 n1 0 2e-08
IL1 0 n1 -3e-06
RP2 vcc n2 126000.0
CP2 n2 0 2e-08
IL2 0 n2 -3e-06
RP3 vcc n3 126000.0
CP3 n3 0 2e-08
IL3 0 n3 -3e-06
RP4 vcc n4 283500.0
CP4 n4 0 2e-08
IL4 0 n4 -1.25e-06
RP5 vcc n5 283500.0
CP5 n5 0 2e-08
IL5 0 n5 -1.25e-06
RP6 vcc n6 283500.0
CP6 n6 0 2e-08
IL6 0 n6 -1.25e-06
RP7 vcc n7 283500.0
CP7 n7 0 2e-08
IL7 0 n7 -1.25e-06
RP8 vcc n8 283500.0
CP8 n8 0 2e-08
IL8 0 n8 -1.25e-06
RP9 vcc n9 283500.0
CP9 n9 0 2e-08
IL9 0 n9 -1.25e-06
RP10 vcc n10 283500.0
CP10 n10 0 2e-08
IL10 0 n10 -1.25e-06
RP11 vcc n11 283500.0
CP11 n11 0 2e-08
IL11 0 n11 -1.25e-06
RP12 vcc n12 283500.0
CP12 n12 0 2e-08
IL12 0 n12 -1.25e-06
RP13 vcc n13 283500.0
CP13 n13 0 2e-08
IL13 0 n13 -1.25e-06
RP14 vcc n14 283500.0
CP14 n14 0 2e-08
IL14 0 n14 -1.25e-06
RP15 vcc n15 283500.0
CP15 n15 0 2e-08
IL15 0 n15 -1.25e-06
RP16 vcc n16 283500.0
CP16 n16 0 2e-08
IL16 0 n16 -1.25e-06
RP17 vcc n17 283500.0
CP17 n17 0 2e-08
IL17 0 n17 -1.25e-06
RP18 vcc n18 283500.0
CP18 n18 0 2e-08
IL18 0 n18 -1.25e-06
RP19 vcc n19 283500.0
CP19 n19 0 2e-08
IL19 0 n19 -1.25e-06
RK0_0 n0 n4 520
RK0_1 n0 n5 100000020.0
RK0_2 n0 n6 100000020.0
RK0_3 n0 n7 100000020.0
RK0_4 n0 n8 100000020.0
RK0_5 n0 n9 100000020.0
RK0_6 n0 n10 100000020.0
RK0_7 n0 n11 100000020.0
RK0_8 n0 n12 100000020.0
RK0_9 n0 n13 100000020.0
RK0_10 n0 n14 100000020.0
RK0_11 n0 n15 100000020.0
RK0_12 n0 n16 100000020.0
RK0_13 n0 n17 100000020.0
RK0_14 n0 n18 100000020.0
RK0_15 n0 n19 100000020.0
RK1_0 n1 n4 100000020.0
RK1_1 n1 n5 100000020.0
RK1_2 n1 n6 100000020.0
RK1_3 n1 n7 100000020.0
RK1_4 n1 n8 100000020.0
RK1_5 n1 n9 100000020.0
RK1_6 n1 n10 100000020.0
RK1_7 n1 n11 100000020.0
RK1_8 n1 n12 100000020.0
RK1_9 n1 n13 100000020.0
RK1_10 n1 n14 100000020.0
RK1_11 n1 n15 100000020.0
RK1_12 n1 n16 100000020.0
RK1_13 n1 n17 100000020.0
RK1_14 n1 n18 100000020.0
RK1_15 n1 n19 100000020.0
RK2_0 n2 n4 100000020.0
RK2_1 n2 n5 100000020.0
RK2_2 n2 n6 100000020.0
RK2_3 n2 n7 100000020.0
RK2_4 n2 n8 100000020.0
RK2_5 n2 n9 100000020.0
RK2_6 n2 n10 100000020.0
RK2_7 n2 n11 100000020.0
RK2_8 n2 n12 100000020.0
RK2_9 n2 n13 100000020.0
RK2_10 n2 n14 100000020.0
RK2_11 n2 n15 100000020.0
RK2_12 n2 n16 100000020.0
RK2_13 n2 n17 100000020.0
RK2_14 n2 n18 100000020.0
RK2_15 n2 n19 100000020.0
RK3_0 n3 n4 100000020.0
RK3_1 n3 n5 100000020.0
RK3_2 n3 n6 100000020.0
RK3_3 n3 n7 100000020.0
RK3_4 n3 n8 100000020.0
RK3_5 n3 n9 100000020.0
RK3_6 n3 n10 100000020.0
RK3_7 n3 n11 100000020.0
RK3_8 n3 n12 100000020.0
RK3_9 n3 n13 100000020.0
RK3_10 n3 n14 100000020.0
RK3_11 n3 n15 100000020.0
RK3_12 n3 n16 100000020.0
RK3_13 n3 n17 100000020.0
RK3_14 n3 n18 100000020.0
RK3_15 n3 n19 100000020.0
.tran 0.5u 2m
.measure tran c0_settled FIND V(n4) AT=1.22m
.measure tran c0_guard FIND V(n4) AT=0.0013216087388282026
.measure tran c1_settled FIND V(n5) AT=1.22m
.measure tran c1_guard FIND V(n5) AT=0.0013216087388282026
.measure tran c2_settled FIND V(n6) AT=1.22m
.measure tran c2_guard FIND V(n6) AT=0.0013216087388282026
.measure tran c3_settled FIND V(n7) AT=1.22m
.measure tran c3_guard FIND V(n7) AT=0.0013216087388282026
.measure tran c4_settled FIND V(n8) AT=1.22m
.measure tran c4_guard FIND V(n8) AT=0.0013216087388282026
.measure tran c5_settled FIND V(n9) AT=1.22m
.measure tran c5_guard FIND V(n9) AT=0.0013216087388282026
.measure tran c6_settled FIND V(n10) AT=1.22m
.measure tran c6_guard FIND V(n10) AT=0.0013216087388282026
.measure tran c7_settled FIND V(n11) AT=1.22m
.measure tran c7_guard FIND V(n11) AT=0.0013216087388282026
.measure tran c8_settled FIND V(n12) AT=1.22m
.measure tran c8_guard FIND V(n12) AT=0.0013216087388282026
.measure tran c9_settled FIND V(n13) AT=1.22m
.measure tran c9_guard FIND V(n13) AT=0.0013216087388282026
.measure tran c10_settled FIND V(n14) AT=1.22m
.measure tran c10_guard FIND V(n14) AT=0.0013216087388282026
.measure tran c11_settled FIND V(n15) AT=1.22m
.measure tran c11_guard FIND V(n15) AT=0.0013216087388282026
.measure tran c12_settled FIND V(n16) AT=1.22m
.measure tran c12_guard FIND V(n16) AT=0.0013216087388282026
.measure tran c13_settled FIND V(n17) AT=1.22m
.measure tran c13_guard FIND V(n17) AT=0.0013216087388282026
.measure tran c14_settled FIND V(n18) AT=1.22m
.measure tran c14_guard FIND V(n18) AT=0.0013216087388282026
.measure tran c15_settled FIND V(n19) AT=1.22m
.measure tran c15_guard FIND V(n19) AT=0.0013216087388282026
.measure tran sink FIND I(VDRV) AT=1.99m
.end
