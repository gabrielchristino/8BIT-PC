Reset-order first-order envelope 107
VRAW source 0 3.94
RDELAY source delayed 10100.0
CDELAY delayed 0 1.05e-09 IC=0.44
ILEAK 0 delayed -1e-06
.tran 0.01u 100u UIC
.measure tran crossing WHEN V(delayed)=3.85 RISE=1
.end
