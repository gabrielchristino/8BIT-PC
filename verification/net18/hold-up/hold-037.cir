NET18 hold-up envelope 37
VCHARGE supply 0 4.6239432002747245
VSW control 0 PWL(0 1 19.999u 1 20u 0)
SISOLATE supply rail control 0 ISOLATE
.model ISOLATE SW(Ron=0.001 Roff=1e15 Vt=0.5 Vh=0)
RESR rail storage 0.005
CBULK storage 0 0.0066
ILOAD rail 0 PWL(0 0.5 19.999u 0.5 20u 0.5)
IREVERSE rail 0 PWL(0 0 19.999u 0 20u 0.5 119.999u 0.5 120u 0)
.tran .05u .2m
.measure tran rail_we FIND V(rail) AT=5.1099999999999995e-05
.measure tran rail_bank FIND V(rail) AT=7.02e-05
.measure tran rail_early FIND V(rail) AT=20.1u
.end
