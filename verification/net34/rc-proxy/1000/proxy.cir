Ideal3.3V+selected37.5ohm source; native series R; not vendor/cable/ESD model
Vsource src 0 PULSE(0 3.3 20n 1n 1n 3.8u 31.78u)
Rsource src buffer 37.5
Rnative buffer connector 75.0
Rreceiver connector 0 2200
Cload connector 0 1000p
.control
set wr_singlescale
set wr_vecnames
tran 1n 8u
wrdata values.dat v(connector)
quit
.endc
.end
