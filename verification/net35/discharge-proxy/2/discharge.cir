Selected passive discharge envelope, NOT LT3042/TPS3808 model
Cbulk store 0 100u IC=3.0108343359965035
RESR store rail 0.05
Iload rail 0 0.005
.control
set wr_singlescale
set wr_vecnames
tran 10n 22u uic
wrdata values.dat v(rail)
quit
.endc
.end
