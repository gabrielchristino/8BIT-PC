Reset-order first-order envelope 128
VRAW source 0 0
RDELAY source delayed 9900
CDELAY delayed 0 1e-12 IC=3.75
ILEAK 0 delayed -1e-06
.tran 0.01u 100u UIC
.measure tran crossing WHEN V(delayed)=3.35 FALL=1
.end
