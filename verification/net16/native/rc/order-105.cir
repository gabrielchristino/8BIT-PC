Reset-order first-order envelope 105
VRAW source 0 0.44
RDELAY source delayed 10100.0
CDELAY delayed 0 1.05e-09 IC=3.94
ILEAK 0 delayed -1e-06
.tran 0.01u 100u UIC
.measure tran crossing WHEN V(delayed)=1.35 FALL=1
.end
